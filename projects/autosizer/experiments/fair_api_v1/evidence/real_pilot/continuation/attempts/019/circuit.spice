* Inverter Analysis from Extracted Netlist
.temp 27
.lib MODEL_SELECTOR tt
.option scale=1e-6
.option warn=0

.subckt SKY130_INV OUT IN VSS VDD
x1 OUT IN VDD VDD sky130_fd_pr__pfet_01v8 w=25.2 l=0.15
x2 OUT IN VSS VSS sky130_fd_pr__nfet_01v8 w=21.0 l=0.15
.ends SKY130_INV

* Main circuit for DC sweep
Vdd VDD 0 DC 1.8
Vss VSS 0 DC 0
Vin IN 0 DC 0 PULSE(0 1.8 100p 100p 100p 1n 2n)
Xinv OUT IN VSS VDD SKY130_INV
Cout OUT 0 10e-15

* DC Sweep Analysis for Gain
.dc Vin 0 1.8 0.01

.control
run

* Calculate DC gain as maximum derivative dVout/dVin
let vout_deriv = deriv(v(OUT))
let gain_linear = abs(vout_deriv)
let gain_db = db(gain_linear)
meas dc dc_gain_db MAX gain_db

print dc_gain_db

.endc

* Transient Analysis for Power and Delay
.control
destroy all
reset

tran 1p 4n

* Calculate power
let power = v(VDD) * (-i(Vdd))
let avg_power_calc = mean(power)

* Measure static current during stable low period (before first pulse)
meas tran static_current AVG i(Vdd) from=10p to=90p
let static_power_abs = abs(static_current) * 1.8

* Dynamic power
let dynamic_power = abs(avg_power_calc - static_power_abs)

* Measurement port: explicit opposite response edges, same thresholds
    meas tran tphl TRIG v(IN) VAL=0.9 RISE=1 TARG v(OUT) VAL=0.9 FALL=1
    meas tran tplh TRIG v(IN) VAL=0.9 FALL=1 TARG v(OUT) VAL=0.9 RISE=1
    let average_delay = (tplh + tphl)/2
    meas tran time_mean_power AVG power from=0 to=4n
    let dynamic_power_timeweighted = abs(time_mean_power - static_power_abs)
    print dynamic_power_timeweighted tphl tplh static_power_abs
    print dynamic_power average_delay

quit
.endc

.end
"""
