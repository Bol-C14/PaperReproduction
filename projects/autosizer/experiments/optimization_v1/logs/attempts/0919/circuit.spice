* Inverter Analysis from Extracted Netlist
.temp 27
.lib /workspace/PaperReproduction/projects/autosizer/tools/sky130_subset.lib.spice tt
.option scale=1e-6
.option warn=0

.subckt SKY130_INV OUT IN VSS VDD
x1 OUT IN VDD VDD sky130_fd_pr__pfet_01v8 w=16.8 l=0.15
x2 OUT IN VSS VSS sky130_fd_pr__nfet_01v8 w=16.8 l=0.15
.ends SKY130_INV

* Main circuit for DC sweep
Vdd VDD 0 DC 1.8
Vss VSS 0 DC 0
Vin IN 0 DC 0 PULSE(0 1.8 100p 100p 100p 1n 2n)
Xinv OUT IN VSS VDD SKY130_INV
Cout OUT 0 10e-15

* DC Sweep Analysis for Gain
.dc Vin 0 1.8 0.01

.control
run

* Calculate DC gain as maximum derivative dVout/dVin
let vout_deriv = deriv(v(OUT))
let gain_linear = abs(vout_deriv)
let gain_db = db(gain_linear)
meas dc dc_gain_db MAX gain_db

print dc_gain_db

.endc

* Transient Analysis for Power and Delay
.control
destroy all
reset

tran 1p 4n

* Calculate power
let power = v(VDD) * (-i(Vdd))
let avg_power_calc = mean(power)

* Measure static current during stable low period (before first pulse)
meas tran static_current AVG i(Vdd) from=10p to=90p
let static_power_abs = abs(static_current) * 1.8

* Dynamic power
let dynamic_power = abs(avg_power_calc - static_power_abs)

* Measure propagation delays at 50% threshold (0.9V)
* Rising edge (LOW to HIGH) - first crossing
meas tran t_in_50_rise WHEN v(IN)=0.9 CROSS=1
meas tran t_out_50_rise WHEN v(OUT)=0.9 CROSS=1
let tplh = t_out_50_rise - t_in_50_rise

* Falling edge (HIGH to LOW) - second crossing
meas tran t_in_50_fall WHEN v(IN)=0.9 CROSS=2
meas tran t_out_50_fall WHEN v(OUT)=0.9 CROSS=2
let tphl = t_out_50_fall - t_in_50_fall
let average_delay = (tplh + tphl)/2

print dynamic_power average_delay

quit
.endc

.end
"""
